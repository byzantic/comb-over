.title Compact Wilkinson, 1 section, f0 = 2.4 GHz on jlc-ro4350b-1.524 (arms modelled as coupled pairs)
# substrate jlc-ro4350b-1.524; arms as coupled pairs (Kirschning–Jansen) at a 1 mm gap; 0603 resistors bridging it
# sections: W 2.1941 mm, 17.1870 mm, R 91 Ω (trimmed); outputs at a 20 mm pitch through two mitred bends each
# input: a 1.778 mm linear taper from the port line to the arms' outer edges (as 4 stepped lines); outputs side by side for 6.58 mm after the resistor (modelled as a coupled pair), then two mitred bends to the 20 mm pitch
# not modelled: where the gap between the arms begins at the taper; the resistor body over the gap (its pads, ESL and body capacitance are)
# trimmed against openEMS by output space mapping (tools/emtrim.mjs, 3 simulations): arms, resistor and input taper chosen so that openEMS meets the goals
# openEMS, 2.160–2.640 GHz (worst): S11 -20.85, S22 -26.40, S32 -23.77 dB; S21 -3.119 … -3.102 dB
# comb-over alone predicts S11 -17.25, S22 -19.22, S32 -22.78 dB; S21 -3.182 … -3.137 dB: its bend and output-split models miss part of what openEMS sees (#47)
.freq 1200000000 3600000000 401
.ref 2400000000
.substrate jlc-ro4350b-1.524
.layout wilkinson pitch=20mm
.param s = 1mm   # gap between the arms (the resistor bridges it)
.param wf = 3.29115mm   # port lines (50 ohm)
.param lt = 1.77756mm   # input taper, from wf to the arms' outer width (2 w1 + s)
.param lo = 6.5823mm   # outputs side by side after the last resistor (a coupled pair), to the first bend's corner
.param w1 = 2.194099mm tune 1.5359mm 3.0717mm
.param l1 = 17.18699mm tune 13.75mm 20.624mm
.param r1 = 91 tune 45.5 182
port in 50
port o1 50
port o2 50
Tin_t1 in in_t1 W=wf+(2*w1+s-wf)*0.125 len=lt/4
Tin_t2 in_t1 in_t2 W=wf+(2*w1+s-wf)*0.375 len=lt/4
Tin_t3 in_t2 in_t3 W=wf+(2*w1+s-wf)*0.625 len=lt/4
Tin_t4 in_t3 in_j W=wf+(2*w1+s-wf)*0.875 len=lt/4
cline K1 geom=msl W=w1 S=s
  len l1
  A in_j in_j
  B a1 b1
end
res R1 a1 b1 R=r1 pkg=0603
step STa a1 a1s W1=w1 W2=wf
cline KO geom=msl W=wf S=s
  len 4.936724mm
  A a1s b1s
  B Oa_1e Ob_1e
end
bend Oa_B1 Oa_1e Oa_2s W=3.29115mm mitre=opt
TOa_2 Oa_2s Oa_2e W=3.29115mm len=4.563276mm
bend Oa_B2 Oa_2e Oa_3s W=3.29115mm mitre=opt
TOa_3 Oa_3s o1 W=3.29115mm len=4.936724mm
step STb b1 b1s W1=w1 W2=wf
bend Ob_B1 Ob_1e Ob_2s W=3.29115mm mitre=opt
TOb_2 Ob_2s Ob_2e W=3.29115mm len=4.563276mm
bend Ob_B2 Ob_2e Ob_3s W=3.29115mm mitre=opt
TOb_3 Ob_3s o2 W=3.29115mm len=4.936724mm
.plot ylim=-50,0 db(S11) db(S21) db(S31) db(S22) db(S32)
