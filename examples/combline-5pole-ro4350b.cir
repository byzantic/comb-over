.title Comb-line chebyshev n=5 0.1dB, f0 = 2 GHz, FBW = 5 % on jlc-ro4350b-0.762 (synthesised geometry)
# substrate jlc-ro4350b-0.762: h 0.762 mm, εr 3.66, copper 34.79 µm; field-solved array
# widths 1.205 1.211 1.24 1.211 1.205 mm; gaps 2.437 3.516 3.516 2.437 mm
# line length 11.513 mm (45.851° at f0, mean modal velocity); tap 2.2802 mm from the shorted end
# shorted ends: 2 × 0.3 mm vias (83.4 pH); open ends: KJK Δl as a capacitance
# realised (lossless): centre 1.99696 GHz, −3 dB FBW 5.555 % (ideal 5.674 %), worst return loss over the central 80 % of the ripple band 16.37 dB (ideal 16.43 dB)
# insertion loss at f0 3.47 dB with the substrate's conductor and dielectric loss (modal Q 171, 173, 174, 175, 175), and the capacitors' Q (300, the default for C0G parts)
# tap junctions: Hammerstad tee (as Qucs); the board layout (.layout) adds the feed lines and edge connectors
# capacitor self-resonance (ESL + vias) 5.9 GHz, under 3 f0: modelled, but above it the capacitors are inductive, so the upper stopband differs from an ideal-capacitor design
.freq 1.6G 2.4G 801
.ref 2G
.substrate jlc-ro4350b-0.762
.layout comb
.param th0 = 45.8505284 tune 44.475 47.226
.param tt = 9.080631 tune 6.356 11.8
.param wf = 1.62658mm   # tap feed width (50 ohm)
.param hw = 3.23879785   # half the feed width in degrees at f0 (the tap junction spans tt ± hw)
.param w1 = 1.20461mm tune 1.02392mm 1.3853mm
.param w2 = 1.2111mm tune 1.02944mm 1.39277mm
.param w3 = 1.24016mm tune 1.05413mm 1.42618mm
.param s12 = 2.43722mm tune 1.94977mm 3.04652mm
.param s23 = 3.51552mm tune 2.81242mm 4.39441mm
.param cl1 = 1.06402p tune 0.904414p 1.22362p
.param cl2 = 0.980074p tune 0.833063p 1.12708p
.param cl3 = 0.987998p tune 0.839798p 1.1362p

port t1 50
port t5 50

cline S1
  geom msl
  W [w1 w2 w3 w2 w1]
  S [s12 s23 s23 s12]
  len (tt-hw)*1deg
  A g1 g2 g3 g4 g5
  B ta1 x2_1 x3_1 x4_1 ta5
end
cline S2
  geom msl
  W [w1 w2 w3 w2 w1]
  S [s12 s23 s23 s12]
  len (2*hw)*1deg
  A - x2_1 x3_1 x4_1 -
  B - x2_2 x3_2 x4_2 -
end
cline S3
  geom msl
  W [w1 w2 w3 w2 w1]
  S [s12 s23 s23 s12]
  len (th0-tt-hw)*1deg
  A tb1 x2_2 x3_2 x4_2 tb5
  B r1 r2 r3 r4 r5
end
tee TJ1 ta1 tb1 t1 Wa=w1 Wb=w1 W2=wf
tee TJ5 ta5 tb5 t5 Wa=w1 Wb=w1 W2=wf
via V1 g1 d=0.3mm n=2
via V2 g2 d=0.3mm n=2
via V3 g3 d=0.3mm n=2
via V4 g4 d=0.3mm n=2
via V5 g5 d=0.3mm n=2
cap C1 r1 C=cl1 type=smd pkg=0603 d=0.3mm n=2
Coe1 r1 0 0.0276669p   # open-end fringing (Δl of a 1.205 mm line)
cap C2 r2 C=cl2 type=smd pkg=0603 d=0.3mm n=2
Coe2 r2 0 0.0275835p   # open-end fringing (Δl of a 1.211 mm line)
cap C3 r3 C=cl3 type=smd pkg=0603 d=0.3mm n=2
Coe3 r3 0 0.0276381p   # open-end fringing (Δl of a 1.24 mm line)
cap C4 r4 C=cl2 type=smd pkg=0603 d=0.3mm n=2
Coe4 r4 0 0.0275835p   # open-end fringing (Δl of a 1.211 mm line)
cap C5 r5 C=cl1 type=smd pkg=0603 d=0.3mm n=2
Coe5 r5 0 0.0276669p   # open-end fringing (Δl of a 1.205 mm line)

.goal db(S11) < -16.43 1952624900 2048624900
.goal db(S21) < -3 1600000000 1942366600   # −3 dB band at most 3 % wider than ideal
.goal db(S21) < -3 2059242600 2400000000
.plot ylim=-70,0 db(S11) db(S21) db(cheby(5,0.1,2000000000,0.05))
.plot gd(S21)
.smith S11
