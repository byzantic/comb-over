.title Compact Wilkinson, 1 section, f0 = 2.4 GHz on jlc-ro4350b-1.524 (arms modelled as independent lines)
# substrate jlc-ro4350b-1.524; arms as independent lines at a 1 mm gap; 0603 resistors bridging it
# sections: W 2.049 mm, 20.4 mm, R 78.27 Ω; outputs at a 12 mm pitch through two mitred bends each
# lossless, 2.16–2.64 GHz: return loss ≥ 20.3 dB (input), ≥ 23.5 dB (outputs); isolation ≥ 20.4 dB; split -3.051 … -3.016 dB
# not modelled: the junction where the input line meets both arms; the resistor body over the gap (its pads, ESL and body capacitance are)
.freq 1200000000 3600000000 401
.ref 2400000000
.substrate jlc-ro4350b-1.524
.layout wilkinson pitch=12mm
.param s = 1mm   # gap between the arms (the resistor bridges it)
.param wf = 3.29115mm   # port lines (50 ohm)
.param w1 = 2.049062mm tune 1.4343mm 2.8687mm
.param l1 = 20.40421mm tune 16.323mm 24.485mm
.param r1 = 78.2716 tune 39.136 156.54
port in 50
port o1 50
port o2 50
T1a in a1 W=w1 len=l1
T1b in b1 W=w1 len=l1
res R1 a1 b1 R=r1 pkg=0603
step STa a1 a1s W1=w1 W2=wf
TOa_1 a1s Oa_1e W=3.29115mm len=4.936724mm
bend Oa_B1 Oa_1e Oa_2s W=3.29115mm mitre=opt
TOa_2 Oa_2s Oa_2e W=3.29115mm len=0.563276mm
bend Oa_B2 Oa_2e Oa_3s W=3.29115mm mitre=opt
TOa_3 Oa_3s o1 W=3.29115mm len=4.936724mm
step STb b1 b1s W1=w1 W2=wf
TOb_1 b1s Ob_1e W=3.29115mm len=4.936724mm
bend Ob_B1 Ob_1e Ob_2s W=3.29115mm mitre=opt
TOb_2 Ob_2s Ob_2e W=3.29115mm len=0.563276mm
bend Ob_B2 Ob_2e Ob_3s W=3.29115mm mitre=opt
TOb_3 Ob_3s o2 W=3.29115mm len=4.936724mm
.goal db(S11) < -20 2160000000 2640000000
.goal db(S22) < -20 2160000000 2640000000
.goal db(S32) < -20 2160000000 2640000000
.plot ylim=-50,0 db(S11) db(S21) db(S31) db(S22) db(S32)
