.title Compact Wilkinson, 1 section, f0 = 2.4 GHz on jlc-ro4350b-1.524 (arms modelled as independent lines)
# substrate jlc-ro4350b-1.524; arms as independent lines at a 1 mm gap; 0603 resistors bridging it
# sections: W 2.011 mm, 16.98 mm, R 91.11 Ω; outputs at a 20 mm pitch through two mitred bends each
# lossless, 2.16–2.64 GHz: return loss ≥ 21.1 dB (input), ≥ 24.8 dB (outputs); isolation ≥ 21.9 dB; split -3.044 … -3.01 dB
# input: a 3.29 mm linear taper from the port line to the arms' outer edges (as 4 stepped lines); outputs side by side for 6.58 mm after the resistor (modelled as a coupled pair), then two mitred bends to the 20 mm pitch
# not modelled: where the gap between the arms begins at the taper; the resistor body over the gap (its pads, ESL and body capacitance are)
.freq 1200000000 3600000000 401
.ref 2400000000
.substrate jlc-ro4350b-1.524
.layout wilkinson pitch=20mm
.param s = 1mm   # gap between the arms (the resistor bridges it)
.param wf = 3.29115mm   # port lines (50 ohm)
.param lt = 3.29115mm   # input taper, from wf to the arms' outer width (2 w1 + s)
.param lo = 6.5823mm   # outputs side by side after the last resistor (a coupled pair), to the first bend's corner
.param w1 = 2.011308mm tune 1.4079mm 2.8158mm
.param l1 = 16.97792mm tune 13.582mm 20.373mm
.param r1 = 91.1111 tune 45.556 182.22
port in 50
port o1 50
port o2 50
Tin_t1 in in_t1 W=wf+(2*w1+s-wf)*0.125 len=lt/4
Tin_t2 in_t1 in_t2 W=wf+(2*w1+s-wf)*0.375 len=lt/4
Tin_t3 in_t2 in_t3 W=wf+(2*w1+s-wf)*0.625 len=lt/4
Tin_t4 in_t3 in_j W=wf+(2*w1+s-wf)*0.875 len=lt/4
T1a in_j a1 W=w1 len=l1
T1b in_j b1 W=w1 len=l1
res R1 a1 b1 R=r1 pkg=0603
step STa a1 a1s W1=w1 W2=wf
cline KO geom=msl W=wf S=s
  len 4.936724mm
  A a1s b1s
  B Oa_1e Ob_1e
end
bend Oa_B1 Oa_1e Oa_2s W=3.29115mm mitre=opt
TOa_2 Oa_2s Oa_2e W=3.29115mm len=4.563276mm
bend Oa_B2 Oa_2e Oa_3s W=3.29115mm mitre=opt
TOa_3 Oa_3s o1 W=3.29115mm len=4.936724mm
step STb b1 b1s W1=w1 W2=wf
bend Ob_B1 Ob_1e Ob_2s W=3.29115mm mitre=opt
TOb_2 Ob_2s Ob_2e W=3.29115mm len=4.563276mm
bend Ob_B2 Ob_2e Ob_3s W=3.29115mm mitre=opt
TOb_3 Ob_3s o2 W=3.29115mm len=4.936724mm
.goal db(S11) < -20 2160000000 2640000000
.goal db(S22) < -20 2160000000 2640000000
.goal db(S32) < -20 2160000000 2640000000
.plot ylim=-50,0 db(S11) db(S21) db(S31) db(S22) db(S32)
